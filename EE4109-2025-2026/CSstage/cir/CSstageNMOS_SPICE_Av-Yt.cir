CSstageNMOS_SPICE_Av-Yt
.lib lib/log018.l TT
.param ID=10u VD=0.9 W=220n L=180n M=1 A=100m f=1Meg RS=10k CS=10p RL=10k CL=1p
B1 g1 0 V=0.9*(1+tanh(I(V1)))
C1 2 7 {CS}
C2 load 0 {CL}
E2 2 1 g1 0 1
F1 0 3 V1 1
I1 0 3 {ID}
I2 0 4 {ID}
I3 0 5 {ID}
I4 0 6 {ID}
M1 3 g1 0 0 nch m={M} w={W} l={L}
M2 4 2 0 0 nch m={M} w={W} l={L}
M3 5 2 0 0 nch m={M} w={W} l={L}
M4 6 7 0 0 nch m={M} w={W} l={L}
R1 2 7 {RS} noisy=1
R2 load 0 {RL} noisy=1
V1 3 0 {VD}
V2 1 0 DC 0 SIN 0 {A} {f} AC 1 0
V3 5 0 {VD}
V4 6 load {VD}
V8 4 out {VD}
.end
