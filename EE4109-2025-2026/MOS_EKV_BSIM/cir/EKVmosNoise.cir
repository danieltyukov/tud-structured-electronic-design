CMOS_noise
.lib SLiCAP_C18.lib
X1 in 0 out  MN18_noise W={W} L={L} ID={I_D}
V1 in 0 1
.end
