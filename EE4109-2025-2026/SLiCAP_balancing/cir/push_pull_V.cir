push_pull_V
.param VP=0.9 VN=0.9 WP=0.73u LP=180n MP=1 WN=220n L_N=180n MN=1 IQ=10u
.lib lib/log018.l TT
B1 V_P gp V=0.9*(1+tanh(1k*(v(V_P)-V(bias_p))))
B2 gn V_N V=0.9*(1+tanh(1k*(V(bias_n)-V(V_N))))
E1 2 1 gp V_P -1
E2 4 3 gn V_N -1
I1 5 V_P {IQ}
I2 V_N dn {IQ}
M1 dn gn V_N V_N nch m={MN} w={WN} l={L_N}
M2 out 3 V_N V_N nch m={MN} w={WN} l={L_N}
M3 5 gp V_P V_P pch m={MP} w={WP} l={LP}
M4 out 1 V_P V_P pch m={MP} w={WP} l={LP}
V1 V_P 0 {VP}
V2 0 V_N {VN}
V3 2 6 {VP}
V4 6 4 {VN}
V5 bias_p 5 {VP}
V6 dn bias_n {VN}
V7 6 0 DC 0
.end
