push_pull_bias
.lib lib/log018.l TT
.param WP=0.73u LP=180n MP=1 WN=220n L_N=180n MN=1
.param R_bias=50k R_P=25k R_N=25k VP=0.9 VN=0.9
M1 2 2 1 1 nch m={MN} w={WN} l={L_N}
M2 out 3 1 1 nch m={MN} w={WN} l={L_N}
M3 5 5 4 4 pch m={MP} w={WP} l={LP}
M4 out 6 4 4 pch m={MP} w={WP} l={LP}
M5 6 5 4 4 pch m={MP} w={WP} l={LP}
M6 3 2 1 1 nch m={MN} w={WN} l={L_N}
R1 5 2 {R_bias} noisy=1
R2 6 7 {R_P} noisy=1
R3 7 3 {R_N} noisy=1
V1 4 0 {VP}
V2 0 1 {VN}
V7 7 0 DC 0
.end
