push_pull_bias_concept
.lib lib/log018.l TT
.param WP=0.73u LP=180n MP=1 WN=220n L_N=180n MN=1
.param R_bias=5k R_P=2.5k R_N=2.5k VP=0.9 VN=0.9 Vgs_P=0 Vgs_N=0
F1 V_P 1 V3 1
F2 2 V_N V4 1
M1 out 1 V_P V_P pch m={MP} w={WP} l={LP}
M2 out 2 V_N V_N nch m={MN} w={WN} l={L_N}
R1 3 4 {R_bias} noisy=1
R2 1 5 {R_P} noisy=1
R3 5 2 {R_N} noisy=1
V1 V_P 0 {VP}
V2 0 V_N {VN}
V3 V_P 3 {Vgs_P}
V4 4 V_N {Vgs_N}
V7 5 0 DC 0
.end
