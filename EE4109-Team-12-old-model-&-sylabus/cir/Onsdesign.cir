"Onsdesign"
* C:\Users\31655\OneDrive - Delft University of Technology\Documenten\__MSc1\Structured\LTSpice - structured\Onsdesign.asc
L1 N003 P001 L value={L_s} iinit=0
R1 N002 N003 R value={R_s} noisetemp=0 noiseflow=0 dcvar=0 dcvarlot=0
R2 N002 N001 R value={R_i} noisetemp=0 noiseflow=0 dcvar=0 dcvarlot=0
C1 N002 0 C value={C_s} vinit=0
C2 N001 out C value={C_i} vinit=0
N1 out 0 N001 0
V1 P001 0 V value=1 dc=0 dcvar=0 noise=0
.param R_i=1
.param R_s=875 C_s={1/(L_s*4*(pi*pi)*(f_c*f_c))} f_c=150k L_s=0.12
.source V1
.detector V_out
.param C_i=1
.backanno
.end
