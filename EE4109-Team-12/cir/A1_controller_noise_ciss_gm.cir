"A1_controller_noise_ciss_gm"
.lib C18.lib
.source V1
.detector V_out
.param Gamma={2/3} alpha={0.6*pi*KF/(n^2*k*T*C_OX)}
.param f_ell={(alpha*f_T)^(1/AF)} f_T={g_m/2/pi/c_iss}
.param L_s=120m R_s=875
E1 out 0 in 0 E value={1/s/tau_i}
V3 1 0 V value=0 noise=0 dc=0 dcvar=0
F1 in 0 V3 F value={s/2/pi/f_T}
V4 2 1 V value=0 noise=0 dc=0 dcvar=0
H1 3 in V4 H value={1/g_m}
I1 0 2 I value=0 noise={4*k*T*n*Gamma*g_m} dc=0 dcvar=0
L1 4 5 L value={L_s} iinit=0
R1 4 6 R value={R_s} noisetemp={T} noiseflow=0 dcvar=0 dcvarlot=0
R3 5 7 R value={R_i} noisetemp={T} noiseflow=0 dcvar=0 dcvarlot=0
V1 6 0 V value=0 noise=0 dc=0 dcvar=0
V2 7 3 V value=0 noise={4*k*T*n*Gamma*f_ell^AF/g_m/f^AF} dc=0 dcvar=0
.end
