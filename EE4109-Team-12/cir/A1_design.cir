A1_design
.source V1
.detector V_out
.param R_s=875 C_s={1/(L_s*4*(pi*pi)*(f_c*f_c))} f_c=150k L_s=0.12
C1 1 0 C value={C_s} vinit=0
C2 3 out C value={C_i} vinit=0
L1 2 4 L value={L_s} iinit=0
N1 out 0 3 0 N
R1 1 3 R value={R_i} noisetemp=0 noiseflow=0 dcvar=0 dcvarlot=0
R2 1 2 R value={R_s} noisetemp=0 noiseflow=0 dcvar=0 dcvarlot=0
V1 4 0 V value=1 noise=0 dc=0 dcvar=0
.end
