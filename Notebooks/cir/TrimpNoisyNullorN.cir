TrimpNoisyNullorN
.param W=220n L=180n M=1 ID=1u VGS=0.5 VDS=0.9
.param C_s=1p C_t=0.2p R_bias=1T
.lib lib/log018.l TT
.inc lib/noisyNullorN.lib
C3 in 0 {C_s}
C4 in out {C_t}
I4 0 in DC 0 AC 1 0
R1 in out {R_bias} noisy=0
X1 0 out in 0 noisyNullorN W={W} L={L} M={M} ID={ID} VGS={VGS} VDS={VDS}
.end
