biasN
.lib lib/log018.l TT
B1 g1 0 V=0.9*(1+tanh(I(V1)))
F1 0 d1 V1 1
I2 0 d1 {ID}
M1 d1 g1 0 0 nch m={M} w={W} l={L}
V1 d1 0 {VDS}
.end
