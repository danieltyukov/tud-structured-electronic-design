feedbackConceptNoisyNullorNspice
.inc lib/DIN_A.lib
.lib lib/log018.l TT
.inc lib/noisyNullorN.lib
C1 in 0 {C_s}
C2 out fb {C_i}
C3 out 0 {C_L}
L1 in 1 {L_s}
R1 1 2 {R_s} noisy=1
R2 in 0 {R_t} noisy=1
R3 fb 0 {R_f} noisy=1
R4 out fb {R_b} noisy=1
V1 2 0 DC 0 AC 1 0
X1 out 0 in fb noisyNullorN VGS={VGS} VDS={VDS} ID={ID} W={W} L={L} M={M}
X2 noise 0 out 0 DIN_A
.end
