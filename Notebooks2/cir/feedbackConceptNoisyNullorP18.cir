feedbackConceptNoisyNullorP18
.source V1
.detector V_out
.lib SLiCAP_C18.lib
.param IG=0
C1 4 0 C value={C_s} vinit=0
C2 out 0 C value={C_L} vinit=0
C3 out 3 C value={C_i} vinit=0
E2 noise 0 out 0 E value={DIN_A}
L1 4 1 L value={L_s} iinit=0
R1 1 2 R value={R_s} noisetemp={T} noiseflow=0 dcvar=0 dcvarlot=0
R2 4 0 R value={R_t} noisetemp={T} noiseflow=0 dcvar=0 dcvarlot=0
R3 3 0 R value={R_f} noisetemp={T} noiseflow=0 dcvar=0 dcvarlot=0
R4 out 3 R value={R_b} noisetemp={T} noiseflow=0 dcvar=0 dcvarlot=0
V1 2 0 V value=0 noise=0 dc=0 dcvar=0
X1 out 0 4 3 MP18_noisyNullor W={W} L={L} ID={ID} IG={IG}
.end
