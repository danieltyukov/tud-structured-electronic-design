dualStageEKV_numeric
.lib "/home/danieltyukov/workspace/tud/tud-structured-electronic-design/Notebooks/lib/SLiCAP_C18.lib"
.param C_L=1.000000e-11
.param C_i=4.955407e-09
.param C_s=9.381591e-12
.param ID1=-8.066134e-06
.param ID2=1.652948e-05
.param L1=7.209231e-07
.param L2=1.800000e-07
.param L_s=1.200000e-01
.param R_b=5.352905e+04
.param R_f=3.241237e+03
.param R_s=8.750000e+02
.param R_t=7.997189e+04
.param T=3.000000e+02
.param W1=1.913099e-05
.param W2=1.000000e-05
.source V1
.detector V_out
.lgref Gm_M1_X2
C2 out 0 C value={C_L} vinit=0
C3 out 4 C value={C_i} vinit=0
C4 in 0 C value={C_s} vinit=0
L1 in 1 L value={L_s} iinit=0
R1 1 2 R value={R_s} noisetemp={T} noiseflow=0 dcvar=0 dcvarlot=0
R2 in 0 R value={R_t} noisetemp={T} noiseflow=0 dcvar=0 dcvarlot=0
R3 4 0 R value={R_f} noisetemp={T} noiseflow=0 dcvar=0 dcvarlot=0
R5 out 4 R value={R_b} noisetemp={T} noiseflow=0 dcvar=0 dcvarlot=0
V1 2 0 V value=0 noise=0 dc=0 dcvar=0
X1 3 0 in 4 CMOS18PD W={W1} L={L1} ID={ID1}
X2 out 3 0 0 CMOS18N W={W2} L={L2} ID={ID2}
.end
