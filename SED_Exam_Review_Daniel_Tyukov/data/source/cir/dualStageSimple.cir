dualStageSimple
.source V1
.detector V_out
.lgref G1
C1 in fb C value={c_iss} vinit=0
C2 out 0 C value={C_L} vinit=0
C3 out fb C value={C_i} vinit=0
C4 in 0 C value={C_s} vinit=0
C5 int 0 C value={c_iss2} vinit=0
G1 int 0 in fb G value={g_m}
G2 out 0 int 0 G value={g_m2}
L1 in 1 L value={L_s} iinit=0
R1 1 2 R value={R_s} noisetemp={T} noiseflow=0 dcvar=0 dcvarlot=0
R2 in 0 R value={R_t} noisetemp={T} noiseflow=0 dcvar=0 dcvarlot=0
R3 fb 0 R value={R_f} noisetemp={T} noiseflow=0 dcvar=0 dcvarlot=0
R4 out fb R value={R_b} noisetemp={T} noiseflow=0 dcvar=0 dcvarlot=0
R5 int 0 R value={1/g_o} noisetemp={T} noiseflow=0 dcvar=0 dcvarlot=0
V1 2 0 V value=0 noise=0 dc=0 dcvar=0
.end
