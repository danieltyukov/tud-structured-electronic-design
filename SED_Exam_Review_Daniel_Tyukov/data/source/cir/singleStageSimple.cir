singleStageSimple
.source V1
.detector V_out
.lgref G1
C1 2 1 C value={c_iss} vinit=0
C2 out 0 C value={C_L} vinit=0
C3 out 1 C value={C_i} vinit=0
C4 2 0 C value={C_s} vinit=0
G1 out 0 2 1 G value={-g_m}
L1 2 3 L value={L_s} iinit=0
R1 3 4 R value={R_s} noisetemp={T} noiseflow=0 dcvar=0 dcvarlot=0
R2 2 0 R value={R_t} noisetemp={T} noiseflow=0 dcvar=0 dcvarlot=0
R3 1 0 R value={R_f} noisetemp={T} noiseflow=0 dcvar=0 dcvarlot=0
R4 out 1 R value={R_b} noisetemp={T} noiseflow=0 dcvar=0 dcvarlot=0
V1 4 0 V value=0 noise=0 dc=0 dcvar=0
.end
