"cfbVamp"
.source V1
.detector V_4
G1 3 5 2 5 G value={g_m}
H1 4 0 3 0 H value={-A_r}
R1 2 1 R value={R_s} noisetemp=0 noiseflow=0 dcvar=0 dcvarlot=0
R2 5 0 R value={R_b} noisetemp=0 noiseflow=0 dcvar=0 dcvarlot=0
R3 4 5 R value={R_a} noisetemp=0 noiseflow=0 dcvar=0 dcvarlot=0
R4 4 0 R value={R_ell} noisetemp=0 noiseflow=0 dcvar=0 dcvarlot=0
V1 1 0 V value={V_s} noise=0 dc=0 dcvar=0
.end
