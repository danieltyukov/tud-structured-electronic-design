"vAmpBlackF"
.source V1
.detector V_3
F1 3 0 2 4 F value={-A_i}
R1 2 1 R value={R_s} noisetemp=0 noiseflow=0 dcvar=0 dcvarlot=0
R2 3 0 R value={R_ell} noisetemp=0 noiseflow=0 dcvar=0 dcvarlot=0
R3 3 4 R value={R_a} noisetemp=0 noiseflow=0 dcvar=0 dcvarlot=0
R4 4 0 R value={R_b} noisetemp=0 noiseflow=0 dcvar=0 dcvarlot=0
V1 1 0 V value={V_s} noise=0 dc=0 dcvar=0
.end
