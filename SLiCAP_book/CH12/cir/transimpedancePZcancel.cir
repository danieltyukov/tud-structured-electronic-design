"transimpedancePZcancel"
.source I1
.lgRef E1
.detector V_2
.param C_s=5p R_f=100k R_ell=2k R_z=5.896k C_z={1/R_z/2/pi/16}
.param C_d=8p C_c=7p A_0=1M R_o=55 G_B=16M
C1 1 0 C value={C_s} vinit=0
C2 1 0 C value={C_d} vinit=0
C3 1 0 C value={C_c/2} vinit=0
C4 3 0 C value={C_z} vinit=0
E1 2 0 1 0 EZ value={-A_0/(1+s/2/pi/16)} zo={R_o}
I1 0 1 I value={I_s} noise=0 dc=0 dcvar=0
R1 1 2 R value={R_f} noisetemp=0 noiseflow=0 dcvar=0 dcvarlot=0
R2 2 0 R value={R_ell} noisetemp=0 noiseflow=0 dcvar=0 dcvarlot=0
R3 1 3 r value={R_z} noisetemp=0 noiseflow=0 dcvar=0 dcvarlot=0
.end
