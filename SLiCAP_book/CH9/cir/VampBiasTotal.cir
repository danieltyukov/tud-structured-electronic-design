"VampBiasTotal"
.detector V_out
R1 1 2 R value={R_a} noisetemp=0 noiseflow=0 dcvar={sigma_R^2} dcvarlot=0
R2 2 0 R value={R_b} noisetemp=0 noiseflow=0 dcvar={sigma_R^2} dcvarlot=0
R3 2 3 R value={R_c} noisetemp=0 noiseflow=0 dcvar={sigma_R^2} dcvarlot=0
R4 4 out R value={(A_v-1)*R} noisetemp=0 noiseflow=0 dcvar={sigma_R^2} dcvarlot=0
V1 1 0 V value=0 noise=0 dc={V_P} dcvar=0
X1 3 4 out 0 O_dcvar svo={v_off} sio={i_off} sib={sigma_ib*I_b} iib={I_b}
.end
